* Behavioral stubs for automation smoke testing only (no SKY130 devices).
* All cells act as an inverter on pin A so the characterization deck toggles the output.
* Replace with real transistor-level subcircuits for production runs.

.subckt invx1 A Y VDD VSS
Einv Y VSS VOL='V(VDD)-V(A)'
.ends invx1

.subckt invx2 A Y VDD VSS
Einv Y VSS VOL='V(VDD)-V(A)'
.ends invx2

.subckt invx4 A Y VDD VSS
Einv Y VSS VOL='V(VDD)-V(A)'
.ends invx4

.subckt invx8 A Y VDD VSS
Einv Y VSS VOL='V(VDD)-V(A)'
.ends invx8

.subckt nand2x1 A B Y VDD VSS
Einv Y VSS VOL='V(VDD)-V(A)'
.ends nand2x1

.subckt nand2x2 A B Y VDD VSS
Einv Y VSS VOL='V(VDD)-V(A)'
.ends nand2x2

.subckt nand2x4 A B Y VDD VSS
Einv Y VSS VOL='V(VDD)-V(A)'
.ends nand2x4

.subckt nor2x1 A B Y VDD VSS
Einv Y VSS VOL='V(VDD)-V(A)'
.ends nor2x1

.subckt nor2x2 A B Y VDD VSS
Einv Y VSS VOL='V(VDD)-V(A)'
.ends nor2x2

.subckt nor2x4 A B Y VDD VSS
Einv Y VSS VOL='V(VDD)-V(A)'
.ends nor2x4

.subckt maj3x1 A B C Y VDD VSS
Einv Y VSS VOL='V(VDD)-V(A)'
.ends maj3x1

.subckt maj3x2 A B C Y VDD VSS
Einv Y VSS VOL='V(VDD)-V(A)'
.ends maj3x2

.subckt maj3x4 A B C Y VDD VSS
Einv Y VSS VOL='V(VDD)-V(A)'
.ends maj3x4
